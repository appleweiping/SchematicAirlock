RAIL oracle: positive ideal inductor at DC
IIN 0 n DC 1
LPATH n 0 1u
.op
.print op v(n)
.end

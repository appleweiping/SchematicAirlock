Parameter precedence oracle: global, header, body, instance
.param a=1
IIN 0 n DC 1
X1 n 0 cell a=4
.subckt cell p n params: a=2
.param a=3
RPATH p n {a}
.ends cell
.op
.print op v(n)
.end

RAIL oracle: modeled temperature-adjusted inductor
IIN 0 n DC 1
LPATH n 0 1u inductor_model dtemp=5
.model inductor_model L tc1=0.001
.op
.print op v(n)
.end

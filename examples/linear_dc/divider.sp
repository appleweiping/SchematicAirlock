* Original literal linear DC example: exactly 3 V output, 1 mA load current
V1 rail 0 DC 5V
R1 rail out 2kohm
R2 out 0 3kohm
.op
.end

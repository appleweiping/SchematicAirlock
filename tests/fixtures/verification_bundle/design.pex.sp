* Original synthetic extracted-view fixture.
.subckt demo_core vin vout vdd 0
RPAR vout vout_x 0.25
CPAR vout_x 0 8f
.ends demo_core

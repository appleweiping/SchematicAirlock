.include cells.lib
VDD vdd 0 1.8
VIN in 0 0.4
X1 in out vdd 0 gain
RLOAD out 0 10k
.op
.end

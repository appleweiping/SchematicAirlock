* Two exact zero-ohm elements form a proven DC path through an internal node.
RZERO1 vdd bridge 0
RZERO2 bridge 0 0
.end

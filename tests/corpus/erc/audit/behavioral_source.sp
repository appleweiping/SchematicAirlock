* A behavioral expression is executable simulator semantics, not a bounded primitive.
VREFERENCE input 0 1
BOPAQUE output 0 V={V(input)*gain}
RINPUT input 0 1k
ROUTPUT output 0 1k
.end

* A single literal zero-ohm strap directly joins the configured rail and ground.
RSTRAP vdd 0 0
.end

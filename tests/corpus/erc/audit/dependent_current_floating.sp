* G and F sources force current but provide no DC voltage reference.
VREFERENCE sense 0 1
GOUTPUT floating 0 sense 0 1m
FOUTPUT floating 0 VREFERENCE 1
.end

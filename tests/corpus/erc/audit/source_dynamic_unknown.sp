* A custom waveform has no statically bounded voltage levels.
VWAVE vdd 0 TABLE(time, 0, 0, 1u, 1)
RLOAD vdd 0 3k
.end

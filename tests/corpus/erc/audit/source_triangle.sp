* Three ideal sources form a loop without being parallel on one node pair.
VA alpha beta 1
VB beta gamma 2
VC gamma alpha -3
RREFERENCE alpha 0 1k
.end

* A capacitor cannot provide a DC path for the resistive island behind it.
VREFERENCE rail 0 1
CCOUPLE rail floating 1p
RCHAIN floating tail 2k
RRETURN tail floating 3k
.end

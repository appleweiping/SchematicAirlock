* A small but non-zero resistance is not an exact DC zero-voltage tie.
VBIAS vdd 0 1.2
RNEAR vdd 0 1m
.end

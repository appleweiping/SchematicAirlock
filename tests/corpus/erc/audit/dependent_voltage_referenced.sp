* E and H outputs impose voltage constraints and reference their shared output.
VREFERENCE sense 0 1
EOUTPUT anchored 0 sense 0 1
HOUTPUT anchored 0 VREFERENCE 1
.end

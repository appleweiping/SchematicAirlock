* A valid positive ideal inductor is a zero-voltage connection at DC.
LRETURN vdd 0 1u
.end

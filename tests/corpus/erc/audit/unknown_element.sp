* An unknown primitive family cannot be assigned trusted electrical semantics.
VREFERENCE rail 0 1
RLOAD rail 0 1k
ZOPAQUE arbitrary tokens
.end

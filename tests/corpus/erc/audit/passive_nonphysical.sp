* A negative inductance is outside this passive-value contract.
VREFERENCE rail 0 1
RLOAD rail 0 2k
LNEGATIVE rail 0 -1n
.end

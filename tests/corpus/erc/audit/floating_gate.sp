* The MOS gate is connected only to an ideal capacitor.
VCORE vdd 0 1.2
MCORE vdd gate 0 0 nch
CGATE gate 0 2p
.end

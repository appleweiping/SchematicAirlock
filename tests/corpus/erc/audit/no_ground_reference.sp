* This two-resistor fragment has no configured reference node at all.
RAB alpha beta 1k
RBA beta alpha 2k
.end

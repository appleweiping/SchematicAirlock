* A literal zero-volt independent source is an exact DC tie across the rails.
VZERO vdd 0 DC 0
.end

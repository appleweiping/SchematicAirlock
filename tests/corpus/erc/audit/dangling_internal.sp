* Spur appears at only one device terminal, but remains DC referenced.
RTAIL spur 0 2k
.end

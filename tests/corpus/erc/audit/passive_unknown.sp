* An unresolved resistance must be reviewed rather than invented.
VREFERENCE rail 0 1
RUNRESOLVED rail 0 {process_resistance}
.end

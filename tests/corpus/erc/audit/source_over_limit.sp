* The literal rail source exceeds the default 20 V artifact ceiling.
VOVER vdd 0 25
RLOAD vdd 0 3k
.end

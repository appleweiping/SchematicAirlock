* VCOMMENTED vdd 0 200
VSAFE vdd 0 1
RLOAD vdd 0 2k
.subckt dormant positive negative
VHIDDEN positive negative 25
.ends dormant
.end

* Parallel ideal sources impose incompatible voltages and close a source loop.
VLEFT rail 0 1
VRIGHT rail 0 2
RLOAD rail 0 1k
.end

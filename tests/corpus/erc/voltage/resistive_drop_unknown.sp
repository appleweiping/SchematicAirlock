* No current/load model proves the voltage after a non-zero resistor.
VSUPPLY rail 0 1.8
RPATH rail sense 1k
.end

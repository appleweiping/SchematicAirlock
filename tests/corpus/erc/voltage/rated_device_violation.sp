* The gate-to-drain voltage is outside the deliberately narrow model rating.
VDD drain 0 1.8
VGATE gate 0 1.0
MCORE drain gate 0 0 narrowmos
.end

* The allowed check overlaps only part of an explicit source PVT envelope.
VSUPPLY rail 0 1.8
.end

* Exact rails keep every explicitly rated MOS and diode terminal pair in range.
VDD drain 0 1.8
VGATE gate 0 1.0
MCORE drain gate 0 0 coremos
DCLAMP gate 0 clampdiode
.end

* Two nominal ideal sources impose different exact voltages on the same node.
VLEFT rail 0 1.8
VRIGHT rail 0 1.9
.end

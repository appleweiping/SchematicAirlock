* The declared output touches only a MOS gate and a capacitor.
VCORE vdd 0 1.2
RLOAD vdd 0 2k
MOBSERVER vdd out 0 0 nch
COUT out 0 1p
.end

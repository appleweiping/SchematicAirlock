* The declared output does not occur in this otherwise referenced divider.
VREFERENCE rail 0 1
RUP rail sense 2k
RDOWN sense 0 2k
.end
